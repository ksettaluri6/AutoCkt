// Design: AAAFOO_TEST_OP_AMP/OPAMP_TWO_STAGE_lch_90n
simulator lang=spectre
global 0
include "/tools/tstech16/CLN16FFC/PDK_RF/models/crn16ffcll_1d8_sp_v1d0_2p1_usage.scs" section=TTMacro_MOS_MOSCAP
include "/tools/tstech16/CLN16FFC/PDK_RF/models/crn16ffcll_1d8_sp_v1d0_2p1_usage.scs" section=TT_RES_BIP_DIO_DISRES
include "/tools/tstech16/CLN16FFC/PDK_RF/models/crn16ffcll_1d8_sp_v1d0_2p1_usage.scs" section=TT_MOM
include "/tools/tstech16/CLN16FFC/PDK_RF/models/crn16ffcll_1d8_sp_v1d0_2p1_usage.scs" section=TT_SCR
include "/tools/tstech16/CLN16FFC/PDK_RF/models/crn16ffcll_1d8_sp_v1d0_2p1_usage.scs" section=TT_R_METAL

parameters cc={{cc}} load={{load}} load2={{load2}} mir={{mir}} gm={{gm}} in={{in}} tail={{tail}}

// BAG_prim/pmos4_standard/schematic
subckt pmos4_standard B D G S
parameters l=60n w=500n nf=1
    M0 (D G S B) pch_lvt_mac l=l nfin=w w=10n+48n*(w-1) multi=1 nf=nf sd=74.0n sa=90n sb=90n ploda1=16.0n ploda2=0 ploda3=0 plodb1=16.0n plodb2=0 plodb3=0 nf_flag=1 smbt=1M smbb=1M dinsaflag=0 ppitch=0 spot=103.00n spob=103.00n spotl1=103.00n spobl1=103.00n spotl2=103.00n spobl2=103.00n spotr1=103.00n spobr1=103.00n spotr2=103.00n spobr2=103.00n
ends pmos4_standard

// BAG_prim/nmos4_standard/schematic
subckt nmos4_standard B D G S
parameters l=60n w=500n nf=1
    M0 (D G S B) nch_lvt_mac l=l nfin=w w=10n+48n*(w-1) multi=1 nf=nf sd=74.0n sa=90n sb=90n ploda1=16.0n ploda2=0 ploda3=0 plodb1=16.0n plodb2=0 plodb3=0 nf_flag=1 smbt=1M smbb=1M dinsaflag=0 ppitch=0 spot=103.00n spob=103.00n spotl1=103.00n spobl1=103.00n spotl2=103.00n spobl2=103.00n spotr1=103.00n spobr1=103.00n spotr2=103.00n spobr2=103.00n
ends nmos4_standard

// AAAFOO_TEST_OP_AMP/OPAMP_TWO_STAGE_lch_90n/schematic
MLOAD2 (VDD net5 net5 VDD) pmos4_standard l=16n w=3 nf=load2
XMGM (VDD vout net8 VDD) pmos4_standard l=16n w=2 nf=gm
XMLOAD (VDD net8 net5 VDD) pmos4_standard l=16n w=2 nf=load2
E0 (inn cm in gnd) vcvs gain=-0.5
E1 (inp cm in gnd) vcvs gain=0.5
XMINP (VSS net8 inp net6) nmos4_standard l=16n w=2 nf=in
XMTAIL (0 net6 ibias 0) nmos4_standard l=16n w=2 nf=tail
XMINN (VSS net5 inn net6) nmos4_standard l=16n w=2 nf=in
XMLOAD3 (0 vout ibias 0) nmos4_standard l=16n w=2 nf=load
XMIR (0 ibias ibias 0) nmos4_standard l=16n w=2 nf=mir
V2 (VDD 0) vsource dc=1.0 type=dc
V1 (cm 0) vsource dc=500.0m type=dc
V0 (in 0) vsource mag=1 type=dc
I1 (VDD ibias) isource dc=10u type=dc
CLOAD (vout 0) capacitor c=10f
CC (vout net8) capacitor c=cc
simulatorOptions options temp=27
ac ac start=1 stop=10G dec=10
dcOp dc
save V2:p V2:p
