// Design: bag_analog_ec/cs_amp
simulator lang=spectre
global 0
parameters nf={{nf}} nfin={{nfin}} r={{res}} vb={{vb}} vdd={{vdd}}
include "/tools/tstech16/CLN16FFC/PDK/tsmcN16/../models/toplevel.scs" section=top_tt

// BAG_prim/nmos4_standard/schematic
subckt nmos4_standard B D G S
parameters l=60n w=500n nf=1
    M0 (D G S B) nch_lvt_mac l=l nfin=w w=10n+48n*(w-1) multi=1 nf=nf sd=74.0n sa=90n sb=90n ploda1=16.0n ploda2=0 ploda3=0 plodb1=16.0n plodb2=0 plodb3=0 nf_flag=1 smbt=1M smbb=1M dinsaflag=0 ppitch=0 spot=103.00n spob=103.00n spotl1=103.00n spobl1=103.00n spotl2=103.00n spobl2=103.00n spotr1=103.00n spobr1=103.00n spotr2=103.00n spobr2=103.00n
ends nmos4_standard

// bag_analog_ec/cs_amp/schematic
X0 (VSS net1 in VSS) nmos4_standard l=90n w=nfin nf=nf
V2 (in VSS) vsource dc=vb mag=1 type=dc
V1 (VSS 0) vsource dc=0 type=dc
V0 (VDD VSS) vsource dc=vdd type=dc
C0 (net1 VSS) capacitor c=20f
R0 (VDD net1) resistor r=r
simulatorOptions options temp=27
ac ac start=1 stop=2T
dcOp dc
