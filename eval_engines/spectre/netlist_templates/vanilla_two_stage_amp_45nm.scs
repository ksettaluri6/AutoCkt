// Design: bag_photonic_links/two_stage_amp
simulator lang=spectre
global 0 sub!
include "/tools/projects/ISG/isg_chips/projects/BAG_45RFSOI_Workspace/cad/lib/models/spectre.model" section=TT
include "/tools/projects/ISG/isg_chips/projects/BAG_45RFSOI_Workspace/cad/lib/lvsres.sp"

parameters cc={{cc}} load={{load}} load2={{load2}} mir={{mir}} gm={{gm}} in={{in}} tail={{tail}}
parameters wload={{wload}} wload2={{wload2}} wmir={{wmir}} wgm={{wgm}} win={{win}} wtail={{wtail}}

// bag_photonic_links/two_stage_amp/schematic
T0 (out net7 VDD sub! VDD) d_avtapfet_bc l=112.00n w=wload2 nf=load2 m=1 gcon=1 optNum=0 diffL=156.00n diffM=224.00n diffR=156.00n diffB=274n local_sigma=0 pu0mult=1e35 pla=0.0 pvta=0 plnest=1 pld200=1 pre_layout_local=-1 pdevdops=1 pdevlgeos=1 pdevwgeos=1 psw_acv_sign=1 agbcp=-1 aebcp=-1 psbcp=-1 pdbcp=-1 pebcp=-1
T7 (net7 net4 VDD sub! VDD) d_avtapfet_bc l=112.00n w=wload nf=load m=1 gcon=1 optNum=0 diffL=156.00n diffM=224.00n diffR=156.00n diffB=274n local_sigma=0 pu0mult=1e35 pla=0.0 pvta=0 plnest=1 pld200=1 pre_layout_local=-1 pdevdops=1 pdevlgeos=1 pdevwgeos=1 psw_acv_sign=1 agbcp=-1 aebcp=-1 psbcp=-1 pdbcp=-1 pebcp=-1
T6 (net4 net4 VDD sub! VDD) d_avtapfet_bc l=112.00n w=wload nf=load m=1 gcon=1 optNum=0 diffL=156.00n diffM=224.00n diffR=156.00n diffB=274n local_sigma=0 pu0mult=1e35 pla=0.0 pvta=0 plnest=1 pld200=1 pre_layout_local=-1 pdevdops=1 pdevlgeos=1 pdevwgeos=1 psw_acv_sign=1 agbcp=-1 aebcp=-1 psbcp=-1 pdbcp=-1 pebcp=-1
V2 (in 0) vsource dc=0 mag=1.0 type=dc
V1 (VDD 0) vsource dc=1.2 type=dc
V3 (cm 0) vsource dc=600.0m type=dc
I0 (VDD net1) isource dc=30u type=dc
C1 (out 0) capacitor c=10p
C0 (out net7) capacitor c=cc
E1 (inp cm in gnd) vcvs gain=0.5
E0 (inn cm in gnd) vcvs gain=-0.5
T2 (net6 net1 0 sub! 0) d_avtanfet_bc l=112.00n w=wtail nf=tail m=1 gcon=1 optNum=0 diffL=156.00n diffM=224.00n diffR=156.00n diffB=274n local_sigma=0 pu0mult=1e35 pla=0.0 pvta=0 plnest=1 pld200=1 pre_layout_local=-1 pdevdops=1 pdevlgeos=1 pdevwgeos=1 psw_acv_sign=1 agbcp=-1 aebcp=-1 psbcp=-1 pdbcp=-1 pebcp=-1
T1 (net4 inn net6 sub! 0) d_avtanfet_bc l=112.00n w=win nf=in m=1 gcon=1 optNum=0 diffL=156.00n diffM=224.00n diffR=156.00n diffB=274n local_sigma=0 pu0mult=1e35 pla=0.0 pvta=0 plnest=1 pld200=1 pre_layout_local=-1 pdevdops=1 pdevlgeos=1 pdevwgeos=1 psw_acv_sign=1 agbcp=-1 aebcp=-1 psbcp=-1 pdbcp=-1 pebcp=-1
T3 (out net1 0 sub! 0) d_avtanfet_bc l=112.00n w=wgm nf=gm m=1 gcon=1 optNum=0 diffL=156.00n diffM=224.00n diffR=156.00n diffB=274n local_sigma=0 pu0mult=1e35 pla=0.0 pvta=0 plnest=1 pld200=1 pre_layout_local=-1 pdevdops=1 pdevlgeos=1 pdevwgeos=1 psw_acv_sign=1 agbcp=-1 aebcp=-1 psbcp=-1 pdbcp=-1 pebcp=-1
T5 (net7 inp net6 sub! 0) d_avtanfet_bc l=112.00n w=win nf=in m=1 gcon=1 optNum=0 diffL=156.00n diffM=224.00n diffR=156.00n diffB=274n local_sigma=0 pu0mult=1e35 pla=0.0 pvta=0 plnest=1 pld200=1 pre_layout_local=-1 pdevdops=1 pdevlgeos=1 pdevwgeos=1 psw_acv_sign=1 agbcp=-1 aebcp=-1 psbcp=-1 pdbcp=-1 pebcp=-1
T4 (net1 net1 0 sub! 0) d_avtnfet_bc l=56.0n w=wmir nf=mir m=1 gcon=1 optNum=0 diffL=206.00n diffM=324.00n diffR=206.00n diffB=226n local_sigma=0 pu0mult=1e35 pla=0.0 pvta=0 plnest=1 pld200=1 pre_layout_local=-1 pdevdops=1 pdevlgeos=1 pdevwgeos=1 psw_acv_sign=1 agbcp=-1 aebcp=-1 psbcp=-1 pdbcp=-1 pebcp=-1
simulatorOptions options temp=27
ac ac start=1 stop=10G dec=10
dcOp dc
