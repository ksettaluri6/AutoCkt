// Design: AAAFOO_TEST_OP_AMP/OPAMP_TWO_STAGE_lch_90n_MEAS_opamp_ac_TB_ac
simulator lang=spectre
global 0
parameters gain_cmfb=2.000000e+02 vincm=5.000000e-01 voutcm=5.000000e-01 cload=2.200000e-14 fndec=1.000000e+01 fstop=1.000000e+10 fstart=1.000000e+04 vdd=1.000000e+00 ibias=2.000000e-06
parameters cc={{cc}} load={{load}} load2={{load2}} mir={{mir}} gm={{gm}} in={{in}} tail={{tail}}
include "/tools/tstech16/CLN16FFC/PDK_RF/models/crn16ffcll_1d8_sp_v1d0_2p1_usage.scs" section=TTMacro_MOS_MOSCAP
include "/tools/tstech16/CLN16FFC/PDK_RF/models/crn16ffcll_1d8_sp_v1d0_2p1_usage.scs" section=TT_RES_BIP_DIO_DISRES
include "/tools/tstech16/CLN16FFC/PDK_RF/models/crn16ffcll_1d8_sp_v1d0_2p1_usage.scs" section=TT_MOM
include "/tools/tstech16/CLN16FFC/PDK_RF/models/crn16ffcll_1d8_sp_v1d0_2p1_usage.scs" section=TT_SCR
include "/tools/tstech16/CLN16FFC/PDK_RF/models/crn16ffcll_1d8_sp_v1d0_2p1_usage.scs" section=TT_R_METAL

// analogLib/ideal_balun/schematic
subckt ideal_balun d c p n
    K0 (d 0 p c) transformer n1=2
    K1 (d 0 c n) transformer n1=2
ends ideal_balun

// BAG_prim/pmos4_standard/schematic
subckt pmos4_standard B D G S
parameters l=60n w=500n nf=1
    M0 (D G S B) pch_lvt_mac l=l nfin=w w=10n+48n*(w-1) multi=1 nf=nf sd=74.0n sa=90n sb=90n ploda1=16.0n ploda2=0 ploda3=0 plodb1=16.0n plodb2=0 plodb3=0 nf_flag=1 smbt=1M smbb=1M dinsaflag=0 ppitch=0 spot=103.00n spob=103.00n spotl1=103.00n spobl1=103.00n spotl2=103.00n spobl2=103.00n spotr1=103.00n spobr1=103.00n spotr2=103.00n spobr2=103.00n
ends pmos4_standard

// BAG_prim/nmos4_standard/schematic
subckt nmos4_standard B D G S
parameters l=60n w=500n nf=1
    M0 (D G S B) nch_lvt_mac l=l nfin=w w=10n+48n*(w-1) multi=1 nf=nf sd=74.0n sa=90n sb=90n ploda1=16.0n ploda2=0 ploda3=0 plodb1=16.0n plodb2=0 plodb3=0 nf_flag=1 smbt=1M smbb=1M dinsaflag=0 ppitch=0 spot=103.00n spob=103.00n spotl1=103.00n spobl1=103.00n spotl2=103.00n spobl2=103.00n spotr1=103.00n spobr1=103.00n spotr2=103.00n spobr2=103.00n
ends nmos4_standard

// AAAFOO_TEST_OP_AMP/OPAMP_TWO_STAGE_lch_90n/schematic
subckt OPAMP_TWO_STAGE_lch_90n out VDD VSS bias inn inp
    MLOAD2 (VDD net5 net5 VDD) pmos4_standard l=16n w=3 nf=load2
    XMGM (VDD out net8 VDD) pmos4_standard l=16n w=2 nf=gm
    XMLOAD (VDD net8 net5 VDD) pmos4_standard l=16n w=2 nf=load2
    XMINP (VSS net8 inp net6) nmos4_standard l=16n w=2 nf=in
    XMTAIL (VSS net6 bias VSS) nmos4_standard l=16n w=2 nf=tail
    XMINN (VSS net5 inn net6) nmos4_standard l=16n w=2 nf=in
    XMLOAD3 (VSS out bias VSS) nmos4_standard l=16n w=2 nf=load
    XMIR (VSS bias bias VSS) nmos4_standard l=16n w=2 nf=mir
    CLOAD (out VSS) capacitor c=cload
    CC (out net8) capacitor c=cc
ends OPAMP_TWO_STAGE_lch_90n

// AAAFOO_TEST_OP_AMP/OPAMP_TWO_STAGE_lch_90n_WRAPPER_opamp_dm/schematic
subckt OPAMP_TWO_STAGE_lch_90n_WRAPPER_opamp_dm out VDD VSS ibias inac indc
    XBALIN (inac indc inp inn) ideal_balun
    I7 (out VDD VSS ibias inn inp) OPAMP_TWO_STAGE_lch_90n
ends OPAMP_TWO_STAGE_lch_90n_WRAPPER_opamp_dm

// AAAFOO_TEST_OP_AMP/OPAMP_TWO_STAGE_lch_90n_MEAS_opamp_ac_TB_ac/schematic
IBIAS (ibias VSS) isource dc=ibias type=dc
VOUTCM (outcm VSS) vsource dc=voutcm mag=1 type=dc
VSUP (VDD VSS) vsource dc=vdd mag=1 type=dc
VINCM (incm VSS) vsource dc=vincm mag=1 type=dc
VGND (VSS 0) vsource dc=0 type=dc
VINAC (vin VSS) vsource dc=0 mag=1 type=dc
I0 (vout VDD VSS ibias vin incm) OPAMP_TWO_STAGE_lch_90n_WRAPPER_opamp_dm
simulatorOptions options temp=27
ac ac start=fstart stop=fstop dec=fndec
dcOp dc
