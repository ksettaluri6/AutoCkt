// Design: bag_analog_ec/folded_cascode_wrapper
simulator lang=spectre
global 0
include "/tools/tstech16/CLN16FFC/PDK/tsmcN16/../models/toplevel.scs" section=top_tt

parameters outn={{outn}} cascn2={{cascn2}} cascn1={{cascn1}} tail1={{tail1}} tail2={{tail2}} in={{in}} outp={{outp}} cascp2={{cascp2}} cascp1={{cascp1}} cfb={{cfb}} rfb={{rfb}}
//parameters outn=1 cascn2=1 cascn1=2 tail1=1 tail2=1 // in=8 outp=1 cascp2=1 // cascp1=1 cfb=1f rfb=100

// BAG_prim/nmos4_standard/schematic
subckt nmos4_standard B D G S
parameters l=60n w=500n nf=1
    M0 (D G S B) nch_lvt_mac l=l nfin=w w=10n+48n*(w-1) multi=1 nf=nf sd=74.0n sa=90n sb=90n ploda1=16.0n ploda2=0 ploda3=0 plodb1=16.0n plodb2=0 plodb3=0 nf_flag=1 smbt=1M smbb=1M dinsaflag=0 ppitch=0 spot=103.00n spob=103.00n spotl1=103.00n spobl1=103.00n spotl2=103.00n spobl2=103.00n spotr1=103.00n spobr1=103.00n spotr2=103.00n spobr2=103.00n
ends nmos4_standard

// BAG_prim/pmos4_standard/schematic
subckt pmos4_standard B D G S
parameters l=60n w=500n nf=1
    M0 (D G S B) pch_lvt_mac l=l nfin=w w=10n+48n*(w-1) multi=1 nf=nf sd=74.0n sa=90n sb=90n ploda1=16.0n ploda2=0 ploda3=0 plodb1=16.0n plodb2=0 plodb3=0 nf_flag=1 smbt=1M smbb=1M dinsaflag=0 ppitch=0 spot=103.00n spob=103.00n spotl1=103.00n spobl1=103.00n spotl2=103.00n spobl2=103.00n spotr1=103.00n spobr1=103.00n spotr2=103.00n spobr2=103.00n
ends pmos4_standard

// bag_analog_ec/folded_cascode/schematic
subckt folded_cascode Voutn Voutp VDD Vbiasn1 Vbiasn2 Vbiasp1 Vbiasp2 Vcmfb Vinn Vinp
    XOUTNN (0 Voutn net8 0) nmos4_standard l=16n w=2 nf=outn
    XOUTPN (0 Voutp net4 0) nmos4_standard l=16n w=2 nf=outn
    XCASCNN2 (0 net18 Vbiasn1 0) nmos4_standard l=16n w=2 nf=cascn2
    XCASCPN2 (0 net17 Vbiasn1 0) nmos4_standard l=16n w=2 nf=cascn2
    XCASCNN1 (0 net8 Vbiasn2 net18) nmos4_standard l=16n w=2 nf=cascn1
    XCASCPN1 (0 net4 Vbiasn2 net17) nmos4_standard l=16n w=2 nf=cascn1
    XTAIL2 (0 net19 Vbiasn1 0) nmos4_standard l=16n w=2 nf=tail2
    XTAIL1 (0 net7 Vbiasn2 net19) nmos4_standard l=16n w=2 nf=tail1
    XINP (0 net13 Vinn net7) nmos4_standard l=16n w=2 nf=in
    XINN (0 net5 Vinp net7) nmos4_standard l=16n w=2 nf=in
    XOUTNP (VDD Voutn Vbiasp2 VDD) pmos4_standard l=16n w=2 nf=outp
    XOUTPP (VDD Voutp Vbiasp2 VDD) pmos4_standard l=16n w=2 nf=outp
    XCASCNP2 (VDD net8 Vcmfb net13) pmos4_standard l=16n w=2 nf=cascp2
    XCASCPP2 (VDD net4 Vcmfb net5) pmos4_standard l=16n w=2 nf=cascp2
    XCASCNP1 (VDD net13 Vbiasp1 VDD) pmos4_standard l=16n w=2 nf=cascp1
    XCASCPP1 (VDD net5 Vbiasp1 VDD) pmos4_standard l=16n w=2 nf=cascp1
    CFBN (net028 Voutn) capacitor c=cfb
    CFBP (net033 net4) capacitor c=cfb
    RFBP (Voutp net033) resistor r=rfb
    RFBN (net8 net028) resistor r=rfb
ends folded_cascode

// analogLib/ideal_balun/schematic
subckt ideal_balun d c p n
    K0 (d 0 p c) transformer n1=2
    K1 (d 0 c n) transformer n1=2
ends ideal_balun

// bag_analog_ec/folded_cascode_wrapper/schematic
I1 (Von Vop VDD Vbiasn1 Vbiasn2 Vbiasp1 Vbiasp2 Vcmfb Vin Vip) folded_cascode
I2 (Voutac Voutdc Vop Von) ideal_balun
XBALIN (Vinac Vindc Vip Vin) ideal_balun
V12 (Vbiasp2 0) vsource dc=600.0m type=dc
V8 (Vbiasp1 0) vsource dc=650m type=dc
V6 (Vbiasn2 0) vsource dc=600m type=dc
V5 (Vbiasn1 0) vsource dc=340m type=dc
V4 (Vcmfb 0) vsource dc=500.0m type=dc
VINAC (Vinac 0) vsource dc=0 mag=1 type=dc
VINDC (Vindc 0) vsource dc=600m type=dc
VDDS (VDD 0) vsource dc=1.0 type=dc
simulatorOptions options temp=27
ac ac start=1k stop=100G
